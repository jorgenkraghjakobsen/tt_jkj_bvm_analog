* ============================================================
* tb_out_buf.spice -- gain, bandwidth, step response, REV 2
*
* REV 1 MODELLED THE PAD AS A 500 OHM SHUNT TO GROUND, which asked
* this buffer for 1.2 V / 500 = 2.4 mA. XM7 is a 20 um device; it
* railed at full overdrive delivering 853 uA and the output stuck at
* 0.4265 V, which then poisoned the .op, the AC sweep (f3db "out of
* interval") and the step response.
*
* The Tiny Tapeout analog spec gives the pad-to-project path as
*   resistance < 500 ohm, capacitance < 5 pF, max current 4 mA
* The 500 ohm is IN SERIES between the project and the pad. The
* correct model is a series R to a pad node, the 5 pF at that node,
* and a high-impedance instrument across it.
*
* Needs .spiceinit in this directory containing:
*     set ngbehavior=hsa
*     set ng_nomodcheck
* ============================================================

.lib $PDK_ROOT/sky130A/libs.tech/ngspice/sky130.lib.spice tt
.include "out_buf.spice"

.param VDD_V = 1.8
.param VCM   = 1.2        $ reference-like operating point
.param IBIAS = 10u        $ matches the DAC deck: out_buf's tail is
*                           W=4 L=1 and the bias diode below is the
*                           same device, so the tail runs at IBIAS
.param RPAD  = 500        $ SERIES pad path, per the TT analog spec
.param CPAD  = 5p         $ pad capacitance, on the far side of RPAD
.param RMEAS = 1meg       $ high-impedance scope / DMM

Vdd VDD 0 {VDD_V}
Vss VSS 0 0

* ---- ideal bias: diode-connected copy of out_buf's tail device ----
Ibias VDD nbias {IBIAS}
XMb   nbias nbias VSS VSS sky130_fd_pr__nfet_01v8 L=1 W=4 nf=1 m=1

* ---- device under test, unity-gain connected ----------------------
* One source serves .op, .ac and .tran: PWL holds VCM through the DC
* and AC analyses and steps at 10 us for the transient, while AC 1
* provides the small-signal drive. Rev 1 required hand-swapping the
* source between runs.
Vin vin 0 PWL(0 {VCM} 10u {VCM} 10.01u {VCM+0.1} 30u {VCM+0.1}) AC 1

Xbuf vin vout nbias VDD VSS out_buf

* ---- TT analog pin model ------------------------------------------
Rpad  vout vpad {RPAD}
Cpad  vpad 0    {CPAD}
Rmeas vpad 0    {RMEAS}

.control
echo ""
echo "============================================================"
echo "  1. OPERATING POINT -- unity gain, so vout should equal vin"
echo "============================================================"
op
print v(vin) v(vout) v(vpad) v(nbias) v(xbuf.ntail) v(xbuf.n1) v(xbuf.n2)
let verr_mv = (v(vout) - v(vin)) * 1e3
print verr_mv
echo "  PASS: |verr_mv| under ~5 mV. A follower's offset is set by"
echo "  input-pair mismatch and finite loop gain, not by the load."
echo "  If vout sits far below vin, the output stage is current"
echo "  limited -- check the load model before touching the cell."
echo ""
echo "  xbuf.ntail should be a few hundred mV, NOT ~0. At ~0 the"
echo "  input pair is starved and nothing below is meaningful."

echo ""
echo "============================================================"
echo "  2. CLOSED-LOOP BANDWIDTH"
echo "============================================================"
ac dec 50 1 1G
let mag_db = db(v(vout))
meas ac gain_lf find mag_db at=10
print gain_lf
echo "  PASS: gain_lf within ~0.1 dB of 0 -- it is a follower."
meas ac f3db when mag_db=-3
echo "  If f3db reports 'out of interval', the gain never reached"
echo "  -3 dB inside 1 Hz..1 GHz, which for a follower means the"
echo "  operating point above is wrong. Fix part 1 first."

echo ""
echo "============================================================"
echo "  3. STEP RESPONSE -- 100 mV step at 10 us"
echo "============================================================"
tran 10n 40u
meas tran v_pre  find v(vout) at=9.5u
meas tran v_post find v(vout) at=29u
let step_mv  = (v_post - v_pre) * 1e3
* 1.3 is hard-coded, not VCM+0.1: .control cannot read a .param.
let step_err = (v_post - 1.3) * 1e3
print v_pre v_post step_mv step_err
echo "  PASS: step_mv near 100, and |step_err| under ~5 mV."
echo "============================================================"
.endc
.end
